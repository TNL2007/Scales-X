| / 7\'7
| \ \   Xilinx Inc.
| / /
| \_\/.\   IBIS Models for ARTIX7 IO
[IBIS ver]   4.2
[File name]   synth_1.ibs
[File Rev]   2.8
[Date]   Thu July 16 10:57:52 2026
[Source]   Derived from spice models, rev1.0, using
   hspice 2010.03-ENG2
[Notes]   Xilinx IBIS file for ARTIX7 I/O standards.
   All models are preliminary.
   The version of IBISCHK used is ibischk5.
   Ibis models were generated using S2IBIS3.
[Disclaimer] The data in this file is derived from SPICE simulations using
                 modeling information extracted from the target process.
                 A great deal of care has been taken to provide information
                 that is accurate. This model has been verified by actual silicon
                 measurement.
[Copyright]   Copyright 2012-2017, Xilinx Inc., All rights reserved
|   Component ARTIX7
[Component]   ARTIX7
[Manufacturer]   Xilinx Inc.
[Package]
|CPG236
|variable   typ   min   max
R_pkg   244m   108.8m   421m
L_pkg   3.92nH   1.48nH   6.88nH
C_pkg   0.53pF   0.25pF   0.932pF
[Pin]   signal_name   model_name  R_pin  L_pin  C_pin
A1   GND   GND
A2   MGTPTXN1_216   NC
A3   GND   GND
A4   MGTPRXN0_216   NC
A5   GND   GND
A6   MGTPRXN1_216   NC
A7   GND   GND
A8   MGTREFCLK0N_216   NC
A9   GND   GND
A10   MGTREFCLK1N_216   NC
A11   DXP_0   NC
A12   VP_0   NC
A13   VREFN_0   NC
A14   IO_L6P_T0_16   NC
A15   IO_L6N_T0_VREF_16   NC
A16   IO_L12P_T1_MRCC_16   NC
A17   IO_L12N_T1_MRCC_16   NC
A18   IO_L19N_T3_VREF_16   NC
A19   GND   GND
B1   MGTAVTT   POWER
B2   MGTPTXP1_216   NC
B3   GND   GND
B4   MGTPRXP0_216   NC
B5   GND   GND
B6   MGTPRXP1_216   NC
B7   GND   GND
B8   MGTREFCLK0P_216   NC
B9   GND   GND
B10   MGTREFCLK1P_216   NC
B11   DXN_0   NC
B12   VREFP_0   NC
B13   VN_0   NC
B14   GND   GND
B15   IO_L11N_T1_SRCC_16   NC
B16   IO_L13N_T2_MRCC_16   NC
B17   IO_L14N_T2_SRCC_16   NC
B18   IO_L19P_T3_16   NC
B19   VCCO_16   POWER
C1   MGTAVCC   POWER
C2   GND   GND
C3   GND   GND
C4   GND   GND
C5   MGTAVTT   POWER
C6   GND   GND
C7   MGTRREF_216   NC
C8   TCK_0   LVCMOS33_F_12_HR
C9   VCCBATT_0   LVCMOS33_F_12_HR
C10   GND   GND
C11   CCLK_0   LVCMOS33_F_12_HR
C12   GNDADC_0   NC
C13   VCCADC_0   NC
C14   VCCO_16   POWER
C15   IO_L11P_T1_SRCC_16   NC
C16   IO_L13P_T2_MRCC_16   NC
C17   IO_L14P_T2_SRCC_16   NC
C18   VCCO_16   POWER
C19   GND   GND
D1   MGTPTXN0_216   NC
D2   MGTPTXP0_216   NC
D3   GND   GND
D17   IO_0_14   NC
D18   D00_D00_MOSI_MOSI   LVCMOS33_F_8_HR
D19   D01_DIN   LVCMOS33_F_8_HR
E1   MGTAVCC   POWER
E2   MGTAVTT   POWER
E3   GND   GND
E17   GND   GND
E18   PUDC_B   LVCMOS33_F_8_HR
E19   out_valid   LVCMOS33_S_12_HR
F1   GND   GND
F2   GND   GND
F3   MGTAVCC   POWER
F17   VCCO_14   POWER
F18   D03   LVCMOS33_F_8_HR
F19   GND   GND
G1   GND   GND
G2   IO_L1N_T0_AD4N_35   NC
G3   IO_L1P_T0_AD4P_35   NC
G7   MGTAVTT   POWER
G8   GND   GND
G9   MGTAVCC   POWER
G10   VCCINT   POWER
G11   GND   GND
G12   VCCO_0   POWER
G13   VCCO_16   POWER
G17   D07   LVCMOS33_F_8_HR
G18   D02   LVCMOS33_F_8_HR
G19   D05   LVCMOS33_F_8_HR
H1   IO_L3P_T0_DQS_AD5P_35   NC
H2   IO_L2P_T0_AD12P_35   NC
H3   VCCO_35   POWER
H7   GND   GND
H8   GND   GND
H9   MGTAVCC   POWER
H10   VCCINT   POWER
H11   GND   GND
H12   GND   GND
H13   VCCAUX   POWER
H17   D06   LVCMOS33_F_8_HR
H18   GND   GND
H19   D04   LVCMOS33_F_8_HR
J1   IO_L3N_T0_DQS_AD5N_35   NC
J2   IO_L2N_T0_AD12N_35   NC
J3   IO_L7P_T1_AD6P_35   NC
J7   VCCO_35   POWER
J8   GND   GND
J9   GND   GND
J10   VCCINT   POWER
J11   GND   GND
J12   GND   GND
J13   VCCAUX   POWER
J17   D09   LVCMOS33_F_8_HR
J18   D10   LVCMOS33_F_8_HR
J19   D08   LVCMOS33_F_8_HR
K1   VCCO_35   POWER
K2   IO_L5P_T0_AD13P_35   NC
K3   IO_L7N_T1_AD6N_35   NC
K7   VCCO_35   POWER
K8   GND   GND
K12   VCCO_14   POWER
K13   VCCO_14   POWER
K17   IO_L12N_T1_MRCC_14   NC
K18   D12   LVCMOS33_F_8_HR
K19   FCS_B   LVCMOS33_F_8_HR
L1   IO_L6N_T0_VREF_35   NC
L2   IO_L5N_T0_AD13N_35   NC
L3   IO_L8P_T1_AD14P_35   NC
L7   VCCO_35   POWER
L8   GND   GND
L9   GND   GND
L10   VCCINT   POWER
L11   GND   GND
L12   VCCO_14   POWER
L13   VCCO_14   POWER
L17   IO_L12P_T1_MRCC_14   NC
L18   D11   LVCMOS33_F_8_HR
L19   GND   GND
M1   IO_L9N_T1_DQS_AD7N_35   NC
M2   IO_L9P_T1_DQS_AD7P_35   NC
M3   IO_L8N_T1_AD14N_35   NC
M7   VCCO_35   POWER
M8   VCCO_34   POWER
M9   GND   GND
M10   VCCINT   POWER
M11   VCCBRAM   POWER
M12   VCCO_14   POWER
M13   GND   GND
M17   VCCO_14   POWER
M18   IO_L11P_T1_SRCC_14   NC
M19   IO_L11N_T1_SRCC_14   NC
N1   IO_L10N_T1_AD15N_35   NC
N2   IO_L10P_T1_AD15P_35   NC
N3   IO_L12P_T1_MRCC_35   NC
N7   VCCO_34   POWER
N8   VCCO_34   POWER
N9   GND   GND
N10   VCCINT   POWER
N11   VCCBRAM   POWER
N12   GND   GND
N13   GND   GND
N17   IO_L13P_T2_MRCC_14   NC
N18   IO_L9P_T1_DQS_14   NC
N19   D13   LVCMOS33_F_8_HR
P1   IO_L19N_T3_VREF_35   NC
P2   GND   GND
P3   IO_L12N_T1_MRCC_35   NC
P17   IO_L13N_T2_MRCC_14   NC
P18   IO_L14P_T2_SRCC_14   NC
P19   D14   LVCMOS33_F_8_HR
R1   VCCO_34   POWER
R2   IO_L1P_T0_34   NC
R3   fi_pos[2]   LVCMOS33_S_8_HR
R17   VCCO_14   POWER
R18   IO_L14N_T2_SRCC_14   NC
R19   D15   LVCMOS33_F_8_HR
T1   IO_L3P_T0_DQS_34   NC
T2   fi_pos[1]   LVCMOS33_S_8_HR
T3   fi_pos[0]   LVCMOS33_S_8_HR
T17   A14_D30   LVCMOS33_F_8_HR
T18   start   LVCMOS33_S_8_HR
T19   GND   GND
U1   fi_pos[4]   LVCMOS33_S_8_HR
U2   IO_L9N_T1_DQS_34   NC
U3   IO_L9P_T1_DQS_34   NC
U4   IO_L11P_T1_SRCC_34   NC
U5   IO_L16P_T2_34   NC
U6   GND   GND
U7   IO_L19P_T3_34   NC
U8   IO_L14P_T2_SRCC_34   NC
U9   GND   GND
U10   M2_0   LVCMOS33_F_12_HR
U11   INIT_B_0   LVCMOS33_F_12_HR
U12   DONE_0   LVCMOS33_F_12_HR
U13   VCCO_14   POWER
U14   IO_25_14   NC
U15   A03_D19   LVCMOS33_F_8_HR
U16   done   LVCMOS33_S_12_HR
U17   A12_D28   LVCMOS33_F_8_HR
U18   A11_D27   LVCMOS33_F_8_HR
U19   error_flag   LVCMOS33_S_12_HR
V1   VCCO_34   POWER
V2   fi_en   LVCMOS33_S_8_HR
V3   IO_L6P_T0_34   NC
V4   IO_L11N_T1_SRCC_34   NC
V5   IO_L16N_T2_34   NC
V6   VCCO_34   POWER
V7   IO_L19N_T3_VREF_34   NC
V8   IO_L14N_T2_SRCC_34   NC
V9   VCCO_0   POWER
V10   PROGRAM_B_0   LVCMOS33_F_12_HR
V11   CFGBVS_0   LVCMOS33_F_12_HR
V12   M0_0   LVCMOS33_F_12_HR
V13   A01_D17   LVCMOS33_F_8_HR
V14   A00_D16   LVCMOS33_F_8_HR
V15   IO_L21P_T3_DQS_14   NC
V16   A10_D26   LVCMOS33_F_8_HR
V17   rst   LVCMOS33_S_8_HR
V18   GND   GND
V19   bank_sel   LVCMOS33_S_12_HR
W1   GND   GND
W2   fi_pos[3]   LVCMOS33_S_8_HR
W3   IO_L6N_T0_VREF_34   NC
W4   IO_L12N_T1_MRCC_34   NC
W5   clk   LVCMOS33_S_8_HR
W6   IO_L13N_T2_MRCC_34   NC
W7   IO_L13P_T2_MRCC_34   NC
W8   TDO_0   LVCMOS33_F_12_HR
W9   TMS_0   LVCMOS33_F_12_HR
W10   TDI_0   LVCMOS33_F_12_HR
W11   M1_0   LVCMOS33_F_12_HR
W12   GND   GND
W13   A05_D21   LVCMOS33_F_8_HR
W14   mode   LVCMOS33_S_8_HR
W15   A06_D22   LVCMOS33_F_8_HR
W16   A08_D24   LVCMOS33_F_8_HR
W17   A07_D23   LVCMOS33_F_8_HR
W18   d_load_next   LVCMOS33_S_12_HR
W19   A15_D31   LVCMOS33_F_8_HR
[Package Model]   xc7a35t_cpg236
[Diff Pin]   inv_pin   vdiff   tdelay_typ   tdelay_min   tdelay_max
[Define Package Model]   xc7a35t_cpg236
[Manufacturer]   Xilinx Inc.
[OEM]   Xilinx
[Description]   236 ball organic wirebond
|[Number of Sections]   1
[Number of Pins]   137
[Pin Numbers]
|[Pin Name]  Net Number   Net Name   Net's All Pins
C11   | 1   CCLK_0   C11
V11   | 2   CFGBVS_0   V11
U12   | 3   DONE_0   U12
B11   | 4   DXN_0   B11
A11   | 5   DXP_0   A11
U11   | 6   INIT_B_0   U11
D17   | 7   IO_0_14   D17
U14   | 8   IO_25_14   U14
T2   | 9   IO_L1N_T0_34   T2
G2   | 10   IO_L1N_T0_AD4N_35   G2
D19   | 11   IO_L1N_T0_D01_DIN_14   D19
R2   | 12   IO_L1P_T0_34   R2
G3   | 13   IO_L1P_T0_AD4P_35   G3
D18   | 14   IO_L1P_T0_D00_MOSI_14   D18
T3   | 15   IO_L2N_T0_34   T3
J2   | 16   IO_L2N_T0_AD12N_35   J2
F18   | 17   IO_L2N_T0_D03_14   F18
R3   | 18   IO_L2P_T0_34   R3
H2   | 19   IO_L2P_T0_AD12P_35   H2
G18   | 20   IO_L2P_T0_D02_14   G18
U1   | 21   IO_L3N_T0_DQS_34   U1
J1   | 22   IO_L3N_T0_DQS_AD5N_35   J1
E19   | 23   IO_L3N_T0_DQS_EMCCLK_14   E19
T1   | 24   IO_L3P_T0_DQS_34   T1
H1   | 25   IO_L3P_T0_DQS_AD5P_35   H1
E18   | 26   IO_L3P_T0_DQS_PUDC_B_14   E18
G19   | 27   IO_L4N_T0_D05_14   G19
H19   | 28   IO_L4P_T0_D04_14   H19
W2   | 29   IO_L5N_T0_34   W2
L2   | 30   IO_L5N_T0_AD13N_35   L2
G17   | 31   IO_L5N_T0_D07_14   G17
V2   | 32   IO_L5P_T0_34   V2
K2   | 33   IO_L5P_T0_AD13P_35   K2
H17   | 34   IO_L5P_T0_D06_14   H17
J19   | 35   IO_L6N_T0_D08_VREF_14   J19
A15   | 36   IO_L6N_T0_VREF_16   A15
W3   | 37   IO_L6N_T0_VREF_34   W3
L1   | 38   IO_L6N_T0_VREF_35   L1
A14   | 39   IO_L6P_T0_16   A14
V3   | 40   IO_L6P_T0_34   V3
K19   | 41   IO_L6P_T0_FCS_B_14   K19
K3   | 42   IO_L7N_T1_AD6N_35   K3
J18   | 43   IO_L7N_T1_D10_14   J18
J3   | 44   IO_L7P_T1_AD6P_35   J3
J17   | 45   IO_L7P_T1_D09_14   J17
M3   | 46   IO_L8N_T1_AD14N_35   M3
K18   | 47   IO_L8N_T1_D12_14   K18
L3   | 48   IO_L8P_T1_AD14P_35   L3
L18   | 49   IO_L8P_T1_D11_14   L18
U2   | 50   IO_L9N_T1_DQS_34   U2
M1   | 51   IO_L9N_T1_DQS_AD7N_35   M1
N19   | 52   IO_L9N_T1_DQS_D13_14   N19
N18   | 53   IO_L9P_T1_DQS_14   N18
U3   | 54   IO_L9P_T1_DQS_34   U3
M2   | 55   IO_L9P_T1_DQS_AD7P_35   M2
N1   | 56   IO_L10N_T1_AD15N_35   N1
R19   | 57   IO_L10N_T1_D15_14   R19
N2   | 58   IO_L10P_T1_AD15P_35   N2
P19   | 59   IO_L10P_T1_D14_14   P19
M19   | 60   IO_L11N_T1_SRCC_14   M19
B15   | 61   IO_L11N_T1_SRCC_16   B15
V4   | 62   IO_L11N_T1_SRCC_34   V4
M18   | 63   IO_L11P_T1_SRCC_14   M18
C15   | 64   IO_L11P_T1_SRCC_16   C15
U4   | 65   IO_L11P_T1_SRCC_34   U4
K17   | 66   IO_L12N_T1_MRCC_14   K17
A17   | 67   IO_L12N_T1_MRCC_16   A17
W4   | 68   IO_L12N_T1_MRCC_34   W4
P3   | 69   IO_L12N_T1_MRCC_35   P3
L17   | 70   IO_L12P_T1_MRCC_14   L17
A16   | 71   IO_L12P_T1_MRCC_16   A16
W5   | 72   IO_L12P_T1_MRCC_34   W5
N3   | 73   IO_L12P_T1_MRCC_35   N3
P17   | 74   IO_L13N_T2_MRCC_14   P17
B16   | 75   IO_L13N_T2_MRCC_16   B16
W6   | 76   IO_L13N_T2_MRCC_34   W6
N17   | 77   IO_L13P_T2_MRCC_14   N17
C16   | 78   IO_L13P_T2_MRCC_16   C16
W7   | 79   IO_L13P_T2_MRCC_34   W7
R18   | 80   IO_L14N_T2_SRCC_14   R18
B17   | 81   IO_L14N_T2_SRCC_16   B17
V8   | 82   IO_L14N_T2_SRCC_34   V8
P18   | 83   IO_L14P_T2_SRCC_14   P18
C17   | 84   IO_L14P_T2_SRCC_16   C17
U8   | 85   IO_L14P_T2_SRCC_34   U8
V19   | 86   IO_L15N_T2_DQS_DOUT_CSO_B_14   V19
U19   | 87   IO_L15P_T2_DQS_RDWR_B_14   U19
V5   | 88   IO_L16N_T2_34   V5
W19   | 89   IO_L16N_T2_A15_D31_14   W19
U5   | 90   IO_L16P_T2_34   U5
W18   | 91   IO_L16P_T2_CSI_B_14   W18
T18   | 92   IO_L17N_T2_A13_D29_14   T18
T17   | 93   IO_L17P_T2_A14_D30_14   T17
U18   | 94   IO_L18N_T2_A11_D27_14   U18
U17   | 95   IO_L18P_T2_A12_D28_14   U17
V17   | 96   IO_L19N_T3_A09_D25_VREF_14   V17
A18   | 97   IO_L19N_T3_VREF_16   A18
V7   | 98   IO_L19N_T3_VREF_34   V7
P1   | 99   IO_L19N_T3_VREF_35   P1
B18   | 100   IO_L19P_T3_16   B18
U7   | 101   IO_L19P_T3_34   U7
V16   | 102   IO_L19P_T3_A10_D26_14   V16
W17   | 103   IO_L20N_T3_A07_D23_14   W17
W16   | 104   IO_L20P_T3_A08_D24_14   W16
W15   | 105   IO_L21N_T3_DQS_A06_D22_14   W15
V15   | 106   IO_L21P_T3_DQS_14   V15
W14   | 107   IO_L22N_T3_A04_D20_14   W14
W13   | 108   IO_L22P_T3_A05_D21_14   W13
U16   | 109   IO_L23N_T3_A02_D18_14   U16
U15   | 110   IO_L23P_T3_A03_D19_14   U15
V14   | 111   IO_L24N_T3_A00_D16_14   V14
V13   | 112   IO_L24P_T3_A01_D17_14   V13
V12   | 113   M0_0   V12
W11   | 114   M1_0   W11
U10   | 115   M2_0   U10
A4   | 116   MGTPRXN0_216   A4
A6   | 117   MGTPRXN1_216   A6
B4   | 118   MGTPRXP0_216   B4
B6   | 119   MGTPRXP1_216   B6
D1   | 120   MGTPTXN0_216   D1
A2   | 121   MGTPTXN1_216   A2
D2   | 122   MGTPTXP0_216   D2
B2   | 123   MGTPTXP1_216   B2
A8   | 124   MGTREFCLK0N_216   A8
B8   | 125   MGTREFCLK0P_216   B8
A10   | 126   MGTREFCLK1N_216   A10
B10   | 127   MGTREFCLK1P_216   B10
C7   | 128   MGTRREF_216   C7
V10   | 129   PROGRAM_B_0   V10
C8   | 130   TCK_0   C8
W10   | 131   TDI_0   W10
W8   | 132   TDO_0   W8
W9   | 133   TMS_0   W9
B13   | 134   VN_0   B13
A12   | 135   VP_0   A12
A13   | 136   VREFN_0   A13
B12   | 137   VREFP_0   B12
[Model Data]
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[End Model Data]
[End Package Model]
| Models and submodels in the file (4): LVCMOS33_F_12_HR (I/O), LVCMOS33_F_8_HR (I/O), LVCMOS33_S_12_HR (I/O), LVCMOS33_S_8_HR (I/O)
